ADE simulation setup
Test Final_Project_PE_GROUP_FO4_1: Final_Project/PE_GROUP_FO4/config, simulator spectre
  Models: /home/ee577@vlab.usc.edu/CDS_GPDK45/gpdk045_v_5_0/gpdk045/../models/spectre/gpdk045.scs[mc]
  Temperature: 27
  Files: vectors /home/samardzi@vlab.usc.edu/work_gpdk045/Final_Project/PE_Group_testcase1.vec
  Stimulus VDD: voltage dc dc=1 srcType=dc
  Stimulus GND: voltage dc dc=0 srcType=dc
  Analysis tran: stop=35n
  Signals: /net32, /net30, /net7, /net23, /net40, /net39, /net35, /net34, /net44, /net43, /net42, /net41, /net9, /net21, /net20, /net19, /net33, /net15, /net64, /net69, /net80, /net83, /net88, /net92, /net94, /net5, /CLK, /net120, /net115, /net114, /net113, /net112, /net111, /net105, /net108, /net109, /net110
Run mode: Single Run, Sweeps and Corners

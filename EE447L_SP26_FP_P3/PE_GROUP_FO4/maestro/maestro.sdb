ADE simulation setup
Run mode: Single Run, Sweeps and Corners
Tests:
  Final_Project_PE_GROUP_FO4_1: Final_Project/PE_GROUP_FO4/config, simulator spectre

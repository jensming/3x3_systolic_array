ADE simulation setup
Test EE447L_SP26_FP_P3_3x3_systolic_array_FO4_1: EE447L_SP26_FP_P3/3x3_systolic_array_FO4/config, simulator spectre
  Models: /home/ee577@vlab.usc.edu/CDS_GPDK45/gpdk045_v_5_0/gpdk045/../models/spectre/gpdk045.scs[mc]
  Temperature: 27
  Files: vectors /home/ensminge@vlab.usc.edu/work_gpdk045/VEC_file/3x3_systolic_array_wcTest.vec
  Stimulus VDD: voltage dc dc=1 srcType=dc
  Stimulus GND: voltage dc dc=0 srcType=dc
  Analysis tran: stop=30n
  Signals: /CLK, /RST_b, /A2_3, /A2_2, /A2_1, /A2_0, /A1_3, /A1_2, /A1_1, /A1_0, /A0_3, /A0_2, /A0_1, /A0_0, /sel_2, /sel_1, /sel_0, /B2_3, /B2_2, /B2_1, /B2_0, /B1_3, /B1_2, /B1_1, /B1_0, /B0_3, /B0_2, /B0_1, /B0_0, /net127, /net129, /net118, /net125, /net113, /net121, /net119, /net111, /net116, /net124, /net109, /net107, /net10, /net98, /net101, /net93, /net91, /net99, /net104, /net96, /net89, /net14, /net8, /net69, /net37, /net35, /net15, /net9, /net78, /net33
Run mode: Single Run, Sweeps and Corners

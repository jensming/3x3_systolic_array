ADE simulation setup
Test EE447L_SP26_FP_P3_3x3_systolic_array_FO4_1: EE447L_SP26_FP_P3/3x3_systolic_array_avgPwr/schematic, simulator spectre
  Models: /home/ee577@vlab.usc.edu/CDS_GPDK45/gpdk045_v_5_0/gpdk045/../models/spectre/gpdk045.scs[mc]
  Temperature: 27
  Files: vectors /home/ensminge@vlab.usc.edu/work_gpdk045/VEC_file/3x3_systolic_array_testcase1.vec
  Stimulus GND: voltage dc dc=0 srcType=dc
  Analysis tran: stop=30n
  Output average(abs_jitter(clip(IT("/V0/PLUS") 3.9e-09 9.1e-09) "rising" 0.0))
  Signals: /V0/PLUS (terminal), /net4
Test EE447L_SP26_FP_P3_3x3_systolic_array_avgPwr_1: EE447L_SP26_FP_P3/3x3_systolic_array_avgPwr/config, simulator spectre
  Models: /home/ee577@vlab.usc.edu/CDS_GPDK45/gpdk045_v_5_0/gpdk045/../models/spectre/gpdk045.scs[mc]
  Temperature: 27
  Files: vectors /home/ensminge@vlab.usc.edu/work_gpdk045/VEC_file/3x3_systolic_array_wcTest.vec
  Stimulus GND: voltage dc dc=0 srcType=dc
  Analysis tran: stop=30n
  Output average(abs(clip((VT("/net4") * IT("/V0/PLUS")) 3.9e-09 9.1e-09)))
  Signals: /V0/PLUS (terminal), /net4

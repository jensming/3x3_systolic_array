ADE simulation setup
Run mode: Single Run, Sweeps and Corners
Tests:
  EE447L_SP26_FP_P3_3x3_systolic_array_avgPwr_1: EE447L_SP26_FP_P3/3x3_systolic_array_avgPwr/config, simulator spectre

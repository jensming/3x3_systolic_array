ADE simulation setup
Run mode: Single Run, Sweeps and Corners
Tests:
  EE477_LAB1_NAND_1X_1: EE477_LAB1/inv_FO4_tb/config, simulator spectre

ADE simulation setup
Test EE477_LAB1_NAND_1X_1
Run mode: Single Run, Sweeps and Corners

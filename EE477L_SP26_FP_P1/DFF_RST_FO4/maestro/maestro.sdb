ADE simulation setup
Run mode: Single Run, Sweeps and Corners
Tests:
  EE477L_SP26_FP_P1_DFF_RST_FO4_1: EE477L_SP26_FP_P1/DFF_RST_FO4/config, simulator spectre

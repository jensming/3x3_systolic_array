ADE simulation setup
Test EE477L_SP26_FP_P1_DFF_RST_FO4_1: EE477L_SP26_FP_P1/DFF_RST_FO4/config, simulator spectre
  Models: /home/ee577@vlab.usc.edu/CDS_GPDK45/gpdk045_v_5_0/gpdk045/../models/spectre/gpdk045.scs[mc]
  Temperature: 27
  Files: vectors /home/ensminge@vlab.usc.edu/work_gpdk045/VEC_file/DFF_RST_io.vec
  Stimulus VDD: voltage dc dc=1 srcType=dc
  Stimulus GND: voltage dc dc=0 srcType=dc
  Analysis tran: stop=11n
  Signals: /net1 as CLK, /net6 as RST_b, /net2 as D, /net3 as Q
Run mode: Single Run, Sweeps and Corners

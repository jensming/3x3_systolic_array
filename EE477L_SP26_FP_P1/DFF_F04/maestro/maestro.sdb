ADE simulation setup
Run mode: Single Run, Sweeps and Corners
Tests:
  EE477L_SP26_FP_P1_DFF_F04_1: EE477L_SP26_FP_P1/DFF_F04/schematic, simulator spectre

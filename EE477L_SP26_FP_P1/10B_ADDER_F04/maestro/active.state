ADE simulation setup
Test Final_Project_10B_ADDER_F04_1: Final_Project/10B_ADDER_F04/schematic, simulator spectre
  Models: /home/ee577@vlab.usc.edu/CDS_GPDK45/gpdk045_v_5_0/gpdk045/../models/spectre/gpdk045.scs[mc]
  Temperature: 27
  Files: vectors /home/samardzi@vlab.usc.edu/work_gpdk045/Final_Project/adder_10bit.vec
  Stimulus VDD: voltage dc dc=1 srcType=dc
  Stimulus GND: voltage dc dc=0 srcType=dc
  Analysis tran: stop=10n
  Signals: /net13 as A9, /net14 as A8, /net15 as A7, /net16 as A6, /net17 as A5, /net18 as A4, /net19 as A3, /net20 as A2, /net21 as A1, /net22 as A0, /net3 as B9, /net4 as B8, /net70 as B7, /net50 as B6, /net7 as B5, /net8 as B4, /net9 as B3, /net10 as B2, /net11 as B1, /net12 as B0, /net23 as S9, /net24 as S8, /net25 as S7, /net26 as S6, /net27 as S5, /net28 as S4, /net29 as S3, /net30 as S2, /net31 as S1, /net32 as S0, /net1 as Cout
Run mode: Single Run, Sweeps and Corners

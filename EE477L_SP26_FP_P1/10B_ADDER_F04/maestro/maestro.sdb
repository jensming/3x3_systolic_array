ADE simulation setup
Run mode: Single Run, Sweeps and Corners
Tests:
  Final_Project_10B_ADDER_F04_1: Final_Project/10B_ADDER_F04/schematic, simulator spectre

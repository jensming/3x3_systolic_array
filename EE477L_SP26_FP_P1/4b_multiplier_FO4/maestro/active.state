ADE simulation setup
Test EE477L_SP26_FP_P1_4b_multiplier_FO4_1: EE477L_SP26_FP_P1/4b_multiplier_FO4/config, simulator spectre
  Models: /home/ee577@vlab.usc.edu/CDS_GPDK45/gpdk045_v_5_0/gpdk045/../models/spectre/gpdk045.scs[mc]
  Temperature: 27
  Files: vectors /home/ensminge@vlab.usc.edu/work_gpdk045/VEC_file/multiplier_4bit_wc.vec
  Stimulus VDD: voltage dc dc=1 srcType=dc
  Stimulus GND: voltage dc dc=0 srcType=dc
  Analysis tran: stop=10n
  Signals: /net2 as B3, /net3 as B2, /net4 as B1, /net5 as B0, /net6 as A3, /net7 as A2, /net8 as A1, /net9 as A0, /net11 as Z7, /net12 as Z6, /net13 as Z5, /net14 as Z4, /net15 as Z3, /net16 as Z2, /net17 as Z1, /net18 as Z0
Run mode: Single Run, Sweeps and Corners

ADE simulation setup
Test Lab3_FA_4b_1: Lab3/FA_4b/schematic, simulator spectre
  Models: /home/ee577@vlab.usc.edu/CDS_GPDK45/gpdk045_v_5_0/gpdk045/../models/spectre/gpdk045.scs[mc]
  Temperature: 27
  Analysis tran: stop=10n
  Signals: /C0, /A0, /B0, /A1, /B1, /A2, /B2, /A3, /B3, /S0, /S1, /S2, /S3, /COUT
Run mode: Single Run, Sweeps and Corners

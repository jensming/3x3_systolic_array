ADE simulation setup
Run mode: Single Run, Sweeps and Corners
Tests:
  Lab3_FA_4b_1: Lab3/FA_4b/schematic, simulator spectre

ADE simulation setup
Run mode: Single Run, Sweeps and Corners
Tests:
  EE477L_SP26_Lab2_NOR_4X_FO4_1: EE477L_SP26_Lab2/NOR_4X_FO4/config, simulator spectre

ADE simulation setup
Test EE477L_SP26_Lab2_NOT_2X_FO4_1: EE477L_SP26_Lab2/NOT_2X_FO4/schematic, simulator spectre
  Models: /home/ee577@vlab.usc.edu/CDS_GPDK45/gpdk045_v_5_0/gpdk045/../models/spectre/gpdk045.scs[mc]
  Temperature: 27
  Stimulus INPUT: voltage bit val1=1 val0=0 rise=10p fall=10p period=1n srcType=bit data=010101
  Stimulus VDD: voltage dc dc=1 srcType=dc
  Stimulus GND: voltage dc dc=0 srcType=dc
  Analysis tran: stop=10n
  Signals: /INPUT as DATA_IN, /net6 as DUT_IN, /net10 as DUT_OUT
Test EE477L_SP26_Lab2_NOT_4X_FO4: EE477L_SP26_Lab2/NOT_4X_FO4/schematic, simulator spectre
  Models: /home/ee577@vlab.usc.edu/CDS_GPDK45/gpdk045_v_5_0/gpdk045/../models/spectre/gpdk045.scs[mc]
  Temperature: 27
  Stimulus INPUT: voltage bit val1=1 val0=0 rise=10p fall=10p period=1n srcType=bit data=010101
  Stimulus VDD: voltage dc dc=1 srcType=dc
  Stimulus GND: voltage dc dc=0 srcType=dc
  Analysis tran: stop=10n
  Signals: /INPUT as DATA_IN, /net6 as DUT_IN, /net10 as DUT_OUT
Test EE477L_SP26_Lab2_NOT_4X_FO4_1: EE477L_SP26_Lab2/NOT_4X_FO4/config, simulator spectre
  Models: /home/ee577@vlab.usc.edu/CDS_GPDK45/gpdk045_v_5_0/gpdk045/../models/spectre/gpdk045.scs[mc]
  Temperature: 27
  Stimulus INPUT: voltage bit val1=1 val0=0 rise=10p fall=10p period=1n srcType=bit data=010101
  Stimulus VDD: voltage dc dc=1 srcType=dc
  Stimulus GND: voltage dc dc=0 srcType=dc
  Analysis tran: stop=10n
  Signals: /INPUT as DATA_IN, /net6 as DUT_IN, /net10 as DUT_OUT

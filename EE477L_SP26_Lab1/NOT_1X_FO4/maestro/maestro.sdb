ADE simulation setup
Run mode: Single Run, Sweeps and Corners
Tests:
  EE477L_SP26_Lab1_NOT_1X_FO4_1: EE477L_SP26_Lab1/NOT_1X_FO4/schematic, simulator spectre

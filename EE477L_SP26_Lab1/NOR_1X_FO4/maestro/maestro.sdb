ADE simulation setup
Run mode: Single Run, Sweeps and Corners
Tests:
  EE477L_SP26_Lab1_NOR_1X_FO4_1: EE477L_SP26_Lab1/NOR_1X_FO4/config, simulator spectre

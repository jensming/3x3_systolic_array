ADE simulation setup
Test EE477L_SP26_Lab1_NAND_1X_FO4_1: EE477L_SP26_Lab1/NAND_1X_FO4/config, simulator spectre
  Models: /home/ee577@vlab.usc.edu/CDS_GPDK45/gpdk045_v_5_0/gpdk045/../models/spectre/gpdk045.scs[mc]
  Temperature: 27
  Stimulus A: voltage bit val1=1 val0=0 delay=0 rise=10p fall=10p period=1n srcType=bit data=01010111
  Stimulus B: voltage bit val1=1 val0=0 delay=0 rise=10p fall=10p period=1n srcType=bit data=00111101
  Stimulus VDD: voltage dc dc=1 srcType=dc
  Stimulus GND: voltage dc dc=0 srcType=dc
  Analysis tran: stop=10n
  Signals: /A as DATA_IN_A, /B as DATA_IN_B, /net10 as DUT_IN_A, /net14 as DUT_IN_B, /net4 as DUT_OUT
Run mode: Single Run, Sweeps and Corners

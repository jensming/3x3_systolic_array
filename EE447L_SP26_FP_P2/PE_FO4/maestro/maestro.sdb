ADE simulation setup
Run mode: Single Run, Sweeps and Corners
Tests:
  Final_Project_PE_FO4_1: EE447L_SP26_FP_P2/PE_FO4/config, simulator spectre

ADE simulation setup
Test Final_Project_PE_FO4_1: EE447L_SP26_FP_P2/PE_FO4/config, simulator spectre
  Models: /home/ee577@vlab.usc.edu/CDS_GPDK45/gpdk045_v_5_0/gpdk045/../models/spectre/gpdk045.scs[mc]
  Temperature: 27
  Files: vectors /home/ensminge@vlab.usc.edu/work_gpdk045/VEC_file/PE_testCases-1.vec
  Stimulus VDD: voltage dc dc=1 srcType=dc
  Stimulus GND: voltage dc dc=0 srcType=dc
  Analysis tran: stop=15n
  Signals: /net7, /net8, /net13, /net9, /net10, /net11, /net12, /net22, /net21, /net20, /net19, /net4, /net53, /net50, /net49, /net46, /net41, /net40, /net60, /net56, /net58, /net32, /net31, /net30, /net29, /net28, /net27, /net26, /net25, /net24, /net23, /net14, /net15, /net16, /net17, /net36, /net35, /net34, /net33, /net18
Run mode: Single Run, Sweeps and Corners

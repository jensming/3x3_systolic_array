ADE simulation setup
Run mode: Single Run, Sweeps and Corners
Tests:
  EE447L_SP26_FP_P2_MAC_FO4_1: EE447L_SP26_FP_P2/MAC_FO4/config, simulator spectre

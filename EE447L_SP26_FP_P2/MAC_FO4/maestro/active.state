ADE simulation setup
Test EE447L_SP26_FP_P2_MAC_FO4_1: EE447L_SP26_FP_P2/MAC_FO4/config, simulator spectre
  Models: /home/ee577@vlab.usc.edu/CDS_GPDK45/gpdk045_v_5_0/gpdk045/../models/spectre/gpdk045.scs[mc]
  Temperature: 27
  Files: vectors /home/ensminge@vlab.usc.edu/work_gpdk045/VEC_file/MAC_testCases.vec
  Stimulus VDD: voltage dc dc=1 srcType=dc
  Stimulus GND: voltage dc dc=0 srcType=dc
  Analysis tran: stop=10n
  Signals: /net4 as B3, /net5 as B2, /net6 as B1, /net7 as B0, /net8 as A3, /net9 as A2, /net10 as A1, /net11 as A0, /net2 as CLK, /net1 as RST_b, /net13 as Z9, /net14 as Z8, /net15 as Z7, /net16 as Z6, /net17 as Z5, /net18 as Z4, /net19 as Z3, /net20 as Z2, /net21 as Z1, /net22 as Z0
Run mode: Single Run, Sweeps and Corners

ADE simulation setup
Test Final_Project_PE_avgPwr_1: Final_Project/PE_avgPwr/config, simulator spectre
  Models: /home/ee577@vlab.usc.edu/CDS_GPDK45/gpdk045_v_5_0/gpdk045/../models/spectre/gpdk045.scs[mc]
  Temperature: 27
  Files: vectors /home/samardzi@vlab.usc.edu/work_gpdk045/Final_Project/PE_testCases.vec
  Stimulus GND: voltage dc dc=0 srcType=dc
  Analysis tran: stop=10n
  Output clip(IT("/V0/PLUS") 2e-09 6e-09)
  Output average(abs(clip(IT("/V0/PLUS") 2e-09 6e-09)))
  Signals: /net1, /V0/PLUS (terminal)
Run mode: Single Run, Sweeps and Corners

ADE simulation setup
Run mode: Single Run, Sweeps and Corners
Tests:
  Final_Project_PE_avgPwr_1: Final_Project/PE_avgPwr/config, simulator spectre

ADE simulation setup
Run mode: Single Run, Sweeps and Corners
Tests:
  EE447L_SP26_FP_P2_MAC_v2_avgPwr_1: EE447L_SP26_FP_P2/MAC_v2_avgPwr/config, simulator spectre

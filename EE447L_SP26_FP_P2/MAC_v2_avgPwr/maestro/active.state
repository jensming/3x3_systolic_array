ADE simulation setup
Test EE447L_SP26_FP_P2_MAC_v2_avgPwr_1: EE447L_SP26_FP_P2/MAC_v2_avgPwr/config, simulator spectre
  Models: /home/ee577@vlab.usc.edu/CDS_GPDK45/gpdk045_v_5_0/gpdk045/../models/spectre/gpdk045.scs[mc]
  Temperature: 27
  Files: vectors /home/ensminge@vlab.usc.edu/work_gpdk045/VEC_file/MAC_testCases.vec
  Stimulus GND: voltage dc dc=0 srcType=dc
  Analysis tran: stop=10n
  Output (VT("/net3") * IT("/V0/PLUS")) (unticked)
  Output clip(IT("/V0/PLUS") 2e-09 6e-09)
  Output average(abs_jitter(clip(IT("/V0/PLUS") 2e-09 6e-09) "rising" 0.0))
  Signals: /net3, /V0/PLUS (terminal)
Run mode: Single Run, Sweeps and Corners

ADE simulation setup
Test EE477L_SP26_Lab3_FA_1b_FO4_1: EE477L_SP26_Lab3/FA_1b_FO4/schematic, simulator spectre
  Models: /home/ee577@vlab.usc.edu/CDS_GPDK45/gpdk045_v_5_0/gpdk045/../models/spectre/gpdk045.scs[mc]
  Temperature: 27
  Files: vectors /home/ensminge@vlab.usc.edu/work_gpdk045/VEC_file/adder_1bit.vec
  Stimulus VDD: voltage dc dc=1 srcType=dc
  Stimulus GND: voltage dc dc=0 srcType=dc
  Analysis tran: stop=10n
  Signals: /net12 as A, /net11 as B, /net9 as Cin, /net8 as Cout, /net13 as S
Test EE477L_SP26_Lab3_FA_1b_opt_CinToS_FO4_1: EE477L_SP26_Lab3/FA_1b_opt_CinToS_FO4/schematic, simulator spectre
  Models: /home/ee577@vlab.usc.edu/CDS_GPDK45/gpdk045_v_5_0/gpdk045/../models/spectre/gpdk045.scs[mc]
  Temperature: 27
  Files: vectors /home/ensminge@vlab.usc.edu/work_gpdk045/VEC_file/adder_1bit.vec
  Stimulus VDD: voltage dc dc=1 srcType=dc
  Stimulus GND: voltage dc dc=0 srcType=dc
  Analysis tran: stop=10n
  Signals: /net5 as A, /net4 as B, /net2 as Cin, /net1 as Cout, /net7 as S
Test EE477L_SP26_Lab3_FA_1b_opt_CinToCout_FO4_1: EE477L_SP26_Lab3/FA_1b_opt_CinToCout_FO4/config, simulator spectre
  Models: /home/ee577@vlab.usc.edu/CDS_GPDK45/gpdk045_v_5_0/gpdk045/../models/spectre/gpdk045.scs[mc]
  Temperature: 27
  Files: vectors /home/ensminge@vlab.usc.edu/work_gpdk045/VEC_file/adder_1bit.vec
  Stimulus VDD: voltage dc dc=1 srcType=dc
  Stimulus GND: voltage dc dc=0 srcType=dc
  Analysis tran: stop=10n
  Signals: /net5 as A, /net4 as B, /net2 as Cin, /net1 as Cout, /net7 as S

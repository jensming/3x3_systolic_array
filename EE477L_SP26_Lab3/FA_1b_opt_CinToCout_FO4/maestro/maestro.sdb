ADE simulation setup
Run mode: Single Run, Sweeps and Corners
Tests:
  EE477L_SP26_Lab3_FA_1b_opt_CinToCout_FO4_1: EE477L_SP26_Lab3/FA_1b_opt_CinToCout_FO4/config, simulator spectre

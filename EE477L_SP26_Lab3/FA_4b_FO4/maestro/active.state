ADE simulation setup
Test EE477L_SP26_Lab3_FA_4b_FO4_1: EE477L_SP26_Lab3/FA_4b_FO4/config, simulator spectre
  Models: /home/ee577@vlab.usc.edu/CDS_GPDK45/gpdk045_v_5_0/gpdk045/../models/spectre/gpdk045.scs[mc]
  Temperature: 27
  Files: vectors /home/ensminge@vlab.usc.edu/work_gpdk045/VEC_file/adder_4bit_worstCase.vec
  Stimulus VDD: voltage dc dc=1 srcType=dc
  Stimulus GND: voltage dc dc=0 srcType=dc
  Analysis tran: stop=10n
  Signals: /net4, /net12, /net11, /net10, /net9, /net8, /net7, /net6, /net5, /net13, /net14, /net15, /net16, /net1
Run mode: Single Run, Sweeps and Corners

ADE simulation setup
Run mode: Single Run, Sweeps and Corners
Tests:
  EE477L_SP26_Lab3_FA_4b_FO4_1: EE477L_SP26_Lab3/FA_4b_FO4/config, simulator spectre
